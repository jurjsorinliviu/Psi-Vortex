* generated Ψ-Vortex OSDI validation
V0 in_0 0 PWL(0 0.20000000298023224 0.00079999920000000009 0.20000000298023224 0.00080000000000000004 0.20000000298023224 0.0015999992 0.20000000298023224 0.0016000000000000001 0.20000000298023224 0.0023999992000000004 0.20000000298023224 0.0024000000000000002 0.20000000298023224 0.0031999992000000003 0.20000000298023224 0.0032000000000000002 0.20000000298023224 0.0039999991999999998 0.20000000298023224 0.0040000000000000001 0.20000000298023224 0.0047999992000000002 0.20000000298023224 0.0048000000000000004 0.20000000298023224 0.0055999991999999997 0.20000000298023224 0.0055999999999999999 0.20000000298023224 0.0063999992 0.20000000298023224 0.0064000000000000003 0.20000000298023224 0.0071999992000000004 0.20000000298023224 0.0072000000000000007 0.20000000298023224 0.0079999991999999999 0.20000000298023224 0.0080000000000000002 0.20000000298023224 0.0087999992000000003 0.20000000298023224 0.0088000000000000005 0.20000000298023224 0.0095999992000000006 0.20000000298023224 0.0096000000000000009 0.20000000298023224 0.010399999200000001 0.20000000298023224 0.010400000000000001 0.20000000298023224 0.0111999992 0.20000000298023224 0.0112 0.20000000298023224 0.0119999992 0.20000000298023224 0.012 0.20000000298023224 0.0127999992 0.20000000298023224 0.012800000000000001 0.20000000298023224 0.013599999200000001 0.20000000298023224 0.013600000000000001 0.20000000298023224 0.014399999200000001 0.20000000298023224 0.014400000000000001 0.20000000298023224 0.0151999992 0.20000000298023224 0.0152 0.20000000298023224 0.0159999992 0.20000000298023224 0.016 0.20000000298023224 0.016799999200000002 0.20000000298023224 0.016800000000000002 0.20000000298023224 0.017599999200000001 0.20000000298023224 0.017600000000000001 0.20000000298023224 0.018399999199999999 0.20000000298023224 0.0184 0.20000000298023224 0.019199999200000002 0.20000000298023224 0.019200000000000002 0.20000000298023224 0.0199999992 0.20000000298023224 0.02 0.20000000298023224 0.020799999200000002 0.20000000298023224 0.020800000000000003 0.20000000298023224 0.021599999200000001 0.20000000298023224 0.021600000000000001 0.20000000298023224 0.022399999199999999 0.20000000298023224 0.0224 0.20000000298023224 0.023199999200000002 0.20000000298023224 0.023200000000000002 0.20000000298023224 0.0239999992 0.20000000298023224 0.024 0.20000000298023224 0.024799999200000002 0.20000000298023224 0.024800000000000003 0.20000000298023224 0.025599999200000001 0.20000000298023224 0.025600000000000001 0.20000000298023224 0.0263999992 0.20000000298023224 0.0264 0.20000000298023224 0.027199999200000002 0.20000000298023224 0.027200000000000002 0.20000000298023224 0.0279999992 0.20000000298023224 0.028000000000000001 0.20000000298023224 0.028799999200000002 0.20000000298023224 0.028800000000000003 0.20000000298023224 0.029599999200000001 0.20000000298023224 0.029600000000000001 0.20000000298023224 0.0303999992 0.20000000298023224 0.0304 0.20000000298023224 0.031199999200000002 0.20000000298023224 0.031200000000000002 0.20000000298023224 0.031999999200000004 0.20000000298023224 0.032000000000000001 0.20000000298023224 0.032799999200000006 0.20000000298023224 0.032800000000000003 0.20000000298023224 0.033599999200000008 0.20000000298023224 0.033600000000000005 0.20000000298023224 0.034399999200000003 0.20000000298023224 0.0344 0.20000000298023224 0.035199999200000005 0.20000000298023224 0.035200000000000002 0.20000000298023224 0.035999999200000007 0.20000000298023224 0.036000000000000004 0.20000000298023224 0.036799999200000003 0.20000000298023224 0.036799999999999999 0.20000000298023224 0.037599999200000005 0.20000000298023224 0.037600000000000001 0.20000000298023224 0.038399999200000007 0.20000000298023224 0.038400000000000004 0.20000000298023224 0.039199999200000002 0.20000000298023224 0.039199999999999999 0.20000000298023224 0.039999999200000004 0.20000000298023224 0.040000000000000001 0.20000000298023224 0.040799999200000006 0.20000000298023224 0.040800000000000003 0.20000000298023224 0.041599999200000008 0.20000000298023224 0.041600000000000005 0.20000000298023224 0.042399999200000003 0.20000000298023224 0.0424 0.20000000298023224 0.043199999200000005 0.20000000298023224 0.043200000000000002 0.20000000298023224 0.043999999200000008 0.20000000298023224 0.044000000000000004 0.20000000298023224 0.044799999200000003 0.20000000298023224 0.0448 0.20000000298023224 0.045599999200000005 0.20000000298023224 0.045600000000000002 0.20000000298023224 0.046399999200000007 0.20000000298023224 0.046400000000000004 0.20000000298023224 0.047199999200000002 0.20000000298023224 0.047199999999999999 0.20000000298023224 0.047999999200000004 0.20000000298023224 0.048000000000000001 0.20000000298023224 0.048799999200000006 0.20000000298023224 0.048800000000000003 0.20000000298023224 0.049599999200000008 0.20000000298023224 0.049600000000000005 0.20000000298023224 0.050399999200000004 0.20000000298023224 0.0504 0.20000000298023224 0.051199999200000006 0.20000000298023224 0.051200000000000002 0.20000000298023224 0.051999999200000008 0.20000000298023224 0.052000000000000005 0.20000000298023224 0.052799999200000003 0.20000000298023224 0.0528 0.20000000298023224 0.053599999200000005 0.20000000298023224 0.053600000000000002 0.20000000298023224 0.054399999200000007 0.20000000298023224 0.054400000000000004 0.20000000298023224 0.055199999200000009 0.20000000298023224 0.055200000000000006 0.20000000298023224 0.055999999200000004 0.20000000298023224 0.056000000000000001 0.20000000298023224 0.056799999200000006 0.20000000298023224 0.056800000000000003 0.20000000298023224 0.057599999200000009 0.20000000298023224 0.057600000000000005 0.20000000298023224 0.058399999200000004 0.20000000298023224 0.058400000000000001 0.20000000298023224 0.059199999200000006 0.20000000298023224 0.059200000000000003 0.20000000298023224 0.059999999200000008 0.20000000298023224 0.060000000000000005 0.20000000298023224 0.060799999200000003 0.20000000298023224 0.0608 0.20000000298023224 0.061599999200000005 0.20000000298023224 0.061600000000000002 0.20000000298023224 0.062399999200000007 0.20000000298023224 0.062400000000000004 0.20000000298023224 0.063199999200000009 0.20000000298023224 0.063200000000000006 0.20000000298023224 0.063999999200000005 0.20000000298023224 0.064000000000000001 0.20000000298023224 0.0647999992 0.20000000298023224 0.064799999999999996 0.20000000298023224 0.065599999200000009 0.20000000298023224 0.065600000000000006 0.20000000298023224 0.066399999200000004 0.20000000298023224 0.066400000000000001 0.20000000298023224 0.067199999200000013 0.20000000298023224 0.06720000000000001 0.20000000298023224 0.067999999200000008 0.20000000298023224 0.068000000000000005 0.20000000298023224 0.068799999200000003 0.20000000298023224 0.0688 0.20000000298023224 0.069599999200000012 0.20000000298023224 0.069600000000000009 0.20000000298023224 0.070399999200000007 0.20000000298023224 0.070400000000000004 0.20000000298023224 0.071199999200000003 0.20000000298023224 0.071199999999999999 0.20000000298023224 0.071999999200000012 0.20000000298023224 0.072000000000000008 0.20000000298023224 0.072799999200000007 0.20000000298023224 0.072800000000000004 0.20000000298023224 0.073599999200000002 0.20000000298023224 0.073599999999999999 0.20000000298023224 0.074399999200000011 0.20000000298023224 0.074400000000000008 0.20000000298023224 0.075199999200000006 0.20000000298023224 0.075200000000000003 0.20000000298023224 0.075999999200000001 0.20000000298023224 0.075999999999999998 0.20000000298023224 0.07679999920000001 0.20000000298023224 0.076800000000000007 0.20000000298023224 0.077599999200000006 0.20000000298023224 0.077600000000000002 0.20000000298023224 0.078399999200000001 0.20000000298023224 0.078399999999999997 0.20000000298023224 0.07919999920000001 0.20000000298023224 0.079200000000000007 0.20000000298023224 0.079999999200000005 0.20000000298023224 0.080000000000000002 0.20000000298023224 0.080799999200000014 0.20000000298023224 0.080800000000000011 0.20000000298023224 0.081599999200000009 0.20000000298023224 0.081600000000000006 0.20000000298023224 0.082399999200000004 0.20000000298023224 0.082400000000000001 0.20000000298023224 0.083199999200000013 0.20000000298023224 0.08320000000000001 0.20000000298023224 0.083999999200000008 0.20000000298023224 0.084000000000000005 0.20000000298023224 0.084799999200000004 0.20000000298023224 0.0848 0.20000000298023224 0.085599999200000013 0.20000000298023224 0.085600000000000009 0.20000000298023224 0.086399999200000008 0.20000000298023224 0.086400000000000005 0.20000000298023224 0.087199999200000003 0.20000000298023224 0.0872 0.20000000298023224 0.087999999200000012 0.20000000298023224 0.088000000000000009 0.20000000298023224 0.088799999200000007 0.20000000298023224 0.088800000000000004 0.20000000298023224 0.089599999200000002 0.20000000298023224 0.089599999999999999 0.20000000298023224 0.090399999200000011 0.20000000298023224 0.090400000000000008 0.20000000298023224 0.091199999200000006 0.20000000298023224 0.091200000000000003 0.20000000298023224 0.091999999200000002 0.20000000298023224 0.091999999999999998 0.20000000298023224 0.092799999200000011 0.20000000298023224 0.092800000000000007 0.20000000298023224 0.093599999200000006 0.20000000298023224 0.093600000000000003 0.20000000298023224 0.094399999200000001 0.20000000298023224 0.094399999999999998 0.20000000298023224 0.09519999920000001 0.20000000298023224 0.095200000000000007 0.20000000298023224 0.095999999200000005 0.20000000298023224 0.096000000000000002 0.20000000298023224 0.096799999200000014 0.20000000298023224 0.096800000000000011 0.20000000298023224 0.097599999200000009 0.20000000298023224 0.097600000000000006 0.20000000298023224 0.098399999200000005 0.20000000298023224 0.098400000000000001 0.20000000298023224 0.099199999200000014 0.20000000298023224 0.09920000000000001 0.20000000298023224 0.099999999200000009 0.20000000298023224 0.10000000000000001 0.20000000298023224 0.1007999992 0.20000000298023224 0.1008 0.20000000298023224 0.10159999920000001 0.20000000298023224 0.10160000000000001 0.20000000298023224 0.10239999920000001 0.20000000298023224 0.1024 0.20000000298023224 0.1031999992 0.20000000298023224 0.1032 0.20000000298023224 0.10399999920000001 0.20000000298023224 0.10400000000000001 0.20000000298023224 0.10479999920000001 0.20000000298023224 0.1048 0.20000000298023224 0.1055999992 0.20000000298023224 0.1056 0.20000000298023224 0.10639999920000001 0.20000000298023224 0.10640000000000001 0.20000000298023224 0.10719999920000001 0.20000000298023224 0.1072 0.20000000298023224 0.1079999992 0.20000000298023224 0.108 0.20000000298023224 0.10879999920000001 0.20000000298023224 0.10880000000000001 0.20000000298023224 0.10959999920000001 0.20000000298023224 0.1096 0.20000000298023224 0.11039999920000002 0.20000000298023224 0.11040000000000001 0.20000000298023224 0.11119999920000001 0.20000000298023224 0.11120000000000001 0.20000000298023224 0.11199999920000001 0.20000000298023224 0.112 0.20000000298023224 0.11279999920000001 0.20000000298023224 0.11280000000000001 0.20000000298023224 0.11359999920000001 0.20000000298023224 0.11360000000000001 0.20000000298023224 0.1143999992 0.20000000298023224 0.1144 0.20000000298023224 0.11519999920000001 0.20000000298023224 0.11520000000000001 0.20000000298023224 0.11599999920000001 0.20000000298023224 0.11600000000000001 0.20000000298023224 0.1167999992 0.20000000298023224 0.1168 0.20000000298023224 0.11759999920000001 0.20000000298023224 0.11760000000000001 0.20000000298023224 0.11839999920000001 0.20000000298023224 0.11840000000000001 0.20000000298023224 0.1191999992 0.20000000298023224 0.1192 0.20000000298023224 0.11999999920000001 0.20000000298023224 0.12000000000000001 0.20000000298023224 0.12079999920000001 0.20000000298023224 0.1208 0.20000000298023224 0.1215999992 0.20000000298023224 0.1216 0.20000000298023224 0.12239999920000001 0.20000000298023224 0.12240000000000001 0.20000000298023224 0.12319999920000001 0.20000000298023224 0.1232 0.20000000298023224 0.1239999992 0.20000000298023224 0.124 0.20000000298023224 0.12479999920000001 0.20000000298023224 0.12480000000000001 0.20000000298023224 0.12559999920000001 0.20000000298023224 0.12560000000000002 0.20000000298023224 0.1263999992 0.20000000298023224 0.12640000000000001 0.20000000298023224 0.1271999992 0.20000000298023224 0.12720000000000001 0.20000000298023224 0.12799999919999999 0.20000000298023224 0.128 0.20000000298023224 0.12879999919999999 0.20000000298023224 0.1288 0.20000000298023224 0.12959999919999998 0.20000000298023224 0.12959999999999999 0.20000000298023224 0.13039999920000001 0.20000000298023224 0.13040000000000002 0.20000000298023224 0.1311999992 0.20000000298023224 0.13120000000000001 0.20000000298023224 0.1319999992 0.20000000298023224 0.13200000000000001 0.20000000298023224 0.13279999919999999 0.20000000298023224 0.1328 0.20000000298023224 0.13359999919999999 0.20000000298023224 0.1336 0.20000000298023224 0.13439999920000001 0.20000000298023224 0.13440000000000002 0.20000000298023224 0.1351999992 0.20000000298023224 0.13520000000000001 0.20000000298023224 0.1359999992 0.20000000298023224 0.13600000000000001 0.20000000298023224 0.13679999919999999 0.20000000298023224 0.1368 0.20000000298023224 0.13759999919999999 0.20000000298023224 0.1376 0.20000000298023224 0.13839999919999998 0.20000000298023224 0.1384 0.20000000298023224 0.13919999920000001 0.20000000298023224 0.13920000000000002 0.20000000298023224 0.1399999992 0.20000000298023224 0.14000000000000001 0.20000000298023224 0.1407999992 0.20000000298023224 0.14080000000000001 0.20000000298023224 0.14159999919999999 0.20000000298023224 0.1416 0.20000000298023224 0.14239999919999999 0.20000000298023224 0.1424 0.20000000298023224 0.14319999919999998 0.20000000298023224 0.14319999999999999 0.20000000298023224 0.14399999920000001 0.20000000298023224 0.14400000000000002 0.20000000298023224 0.1447999992 0.20000000298023224 0.14480000000000001 0.20000000298023224 0.1455999992 0.20000000298023224 0.14560000000000001 0.20000000298023224 0.14639999919999999 0.20000000298023224 0.1464 0.20000000298023224 0.14719999919999999 0.20000000298023224 0.1472 0.20000000298023224 0.14799999920000001 0.20000000298023224 0.14800000000000002 0.20000000298023224 0.1487999992 0.20000000298023224 0.14880000000000002 0.20000000298023224 0.1495999992 0.20000000298023224 0.14960000000000001 0.20000000298023224 0.1503999992 0.20000000298023224 0.15040000000000001 0.20000000298023224 0.15119999919999999 0.20000000298023224 0.1512 0.20000000298023224 0.15199999919999999 0.20000000298023224 0.152 0.20000000298023224 0.15279999920000001 0.20000000298023224 0.15280000000000002 0.20000000298023224 0.1535999992 0.20000000298023224 0.15360000000000001 0.20000000298023224 0.1543999992 0.20000000298023224 0.15440000000000001 0.20000000298023224 0.15519999919999999 0.20000000298023224 0.1552 0.20000000298023224 0.15599999919999999 0.20000000298023224 0.156 0.20000000298023224 0.15679999919999998 0.20000000298023224 0.15679999999999999 0.20000000298023224 0.15759999920000001 0.20000000298023224 0.15760000000000002 0.20000000298023224 0.1583999992 0.20000000298023224 0.15840000000000001 0.20000000298023224 0.1591999992 0.20000000298023224 0.15920000000000001 0.20000000298023224 0.15999999919999999 0.20000000298023224 0.16 0.20000000298023224 0.16079999919999999 0.20000000298023224 0.1608 0.20000000298023224 0.16159999920000001 0.20000000298023224 0.16160000000000002 0.20000000298023224 0.16239999920000001 0.20000000298023224 0.16240000000000002 0.20000000298023224 0.1631999992 0.20000000298023224 0.16320000000000001 0.20000000298023224 0.1639999992 0.20000000298023224 0.16400000000000001 0.20000000298023224 0.16479999919999999 0.20000000298023224 0.1648 0.20000000298023224 0.16559999919999999 0.20000000298023224 0.1656 0.20000000298023224 0.16639999920000001 0.20000000298023224 0.16640000000000002 0.20000000298023224 0.1671999992 0.20000000298023224 0.16720000000000002 0.20000000298023224 0.1679999992 0.20000000298023224 0.16800000000000001 0.20000000298023224 0.16879999919999999 0.20000000298023224 0.16880000000000001 0.20000000298023224 0.16959999919999999 0.20000000298023224 0.1696 0.20000000298023224 0.17039999919999999 0.20000000298023224 0.1704 0.20000000298023224 0.17119999920000001 0.20000000298023224 0.17120000000000002 0.20000000298023224 0.1719999992 0.20000000298023224 0.17200000000000001 0.20000000298023224 0.1727999992 0.20000000298023224 0.17280000000000001 0.20000000298023224 0.17359999919999999 0.20000000298023224 0.1736 0.20000000298023224 0.17439999919999999 0.20000000298023224 0.1744 0.20000000298023224 0.17519999919999998 0.20000000298023224 0.17519999999999999 0.20000000298023224 0.17599999920000001 0.20000000298023224 0.17600000000000002 0.20000000298023224 0.1767999992 0.20000000298023224 0.17680000000000001 0.20000000298023224 0.1775999992 0.20000000298023224 0.17760000000000001 0.20000000298023224 0.17839999919999999 0.20000000298023224 0.1784 0.20000000298023224 0.17919999919999999 0.20000000298023224 0.1792 0.20000000298023224 0.17999999920000001 0.20000000298023224 0.18000000000000002 0.20000000298023224 0.18079999920000001 0.20000000298023224 0.18080000000000002 0.20000000298023224 0.1815999992 0.20000000298023224 0.18160000000000001 0.20000000298023224 0.1823999992 0.20000000298023224 0.18240000000000001 0.20000000298023224 0.18319999919999999 0.20000000298023224 0.1832 0.20000000298023224 0.18399999919999999 0.20000000298023224 0.184 0.20000000298023224 0.18479999920000001 0.20000000298023224 0.18480000000000002 0.20000000298023224 0.1855999992 0.20000000298023224 0.18560000000000001 0.20000000298023224 0.1863999992 0.20000000298023224 0.18640000000000001 0.20000000298023224 0.18719999919999999 0.20000000298023224 0.18720000000000001 0.20000000298023224 0.18799999919999999 0.20000000298023224 0.188 0.20000000298023224 0.18879999919999998 0.20000000298023224 0.1888 0.20000000298023224 0.18959999920000001 0.20000000298023224 0.18960000000000002 0.20000000298023224 0.1903999992 0.20000000298023224 0.19040000000000001 0.20000000298023224 0.1911999992 0.20000000298023224 0.19120000000000001 0.20000000298023224 0.19199999919999999 0.20000000298023224 0.192 0.20000000298023224 0.19279999919999999 0.20000000298023224 0.1928 0.20000000298023224 0.19359999920000001 0.20000000298023224 0.19360000000000002 0.20000000298023224 0.19439999920000001 0.20000000298023224 0.19440000000000002 0.20000000298023224 0.1951999992 0.20000000298023224 0.19520000000000001 0.20000000298023224 0.1959999992 0.20000000298023224 0.19600000000000001 0.20000000298023224 0.19679999919999999 0.20000000298023224 0.1968 0.20000000298023224 0.19759999919999999 0.20000000298023224 0.1976 0.20000000298023224 0.19839999920000001 0.20000000298023224 0.19840000000000002 0.20000000298023224 0.19919999920000001 0.20000000298023224 0.19920000000000002 0.20000000298023224 0.1999999992 0.20000000298023224 0.20000000000000001 0.20000000298023224 0.2007999992 0.20000000298023224 0.20080000000000001 0.20000000298023224)
Vclock sample_clock 0 PWL(0 0 0.00039999920000000002 0 0.00040000000000000002 1 0.00079999920000000009 1 0.00080000000000000004 0 0.0011999992000000001 0 0.0012000000000000001 1 0.0015999992 1 0.0016000000000000001 0 0.0019999992000000002 0 0.002 1 0.0023999992000000004 1 0.0024000000000000002 0 0.0027999992000000001 0 0.0028 1 0.0031999992000000003 1 0.0032000000000000002 0 0.0035999992000000005 0 0.0036000000000000003 1 0.0039999991999999998 1 0.0040000000000000001 0 0.0043999992 0 0.0044000000000000003 1 0.0047999992000000002 1 0.0048000000000000004 0 0.0051999992000000004 0 0.0052000000000000006 1 0.0055999991999999997 1 0.0055999999999999999 0 0.0059999991999999999 0 0.0060000000000000001 1 0.0063999992 1 0.0064000000000000003 0 0.0067999992000000002 0 0.0068000000000000005 1 0.0071999992000000004 1 0.0072000000000000007 0 0.0075999991999999997 0 0.0076 1 0.0079999991999999999 1 0.0080000000000000002 0 0.0083999992000000009 0 0.0084000000000000012 1 0.0087999992000000003 1 0.0088000000000000005 0 0.0091999991999999996 0 0.0091999999999999998 1 0.0095999992000000006 1 0.0096000000000000009 0 0.0099999991999999999 0 0.01 1 0.010399999200000001 1 0.010400000000000001 0 0.0107999992 0 0.010800000000000001 1 0.0111999992 1 0.0112 0 0.011599999200000001 0 0.011600000000000001 1 0.0119999992 1 0.012 0 0.012399999200000001 0 0.012400000000000001 1 0.0127999992 1 0.012800000000000001 0 0.0131999992 0 0.0132 1 0.013599999200000001 1 0.013600000000000001 0 0.0139999992 0 0.014 1 0.014399999200000001 1 0.014400000000000001 0 0.0147999992 0 0.014800000000000001 1 0.0151999992 1 0.0152 0 0.015599999200000001 0 0.015600000000000001 1 0.0159999992 1 0.016 0 0.016399999200000001 0 0.016400000000000001 1 0.016799999200000002 1 0.016800000000000002 0 0.0171999992 0 0.0172 1 0.017599999200000001 1 0.017600000000000001 0 0.017999999200000002 0 0.018000000000000002 1 0.018399999199999999 1 0.0184 0 0.0187999992 0 0.018800000000000001 1 0.019199999200000002 1 0.019200000000000002 0 0.019599999199999999 0 0.019599999999999999 1 0.0199999992 1 0.02 0 0.020399999200000001 0 0.020400000000000001 1 0.020799999200000002 1 0.020800000000000003 0 0.0211999992 0 0.0212 1 0.021599999200000001 1 0.021600000000000001 0 0.021999999200000002 0 0.022000000000000002 1 0.022399999199999999 1 0.0224 0 0.022799999200000001 0 0.022800000000000001 1 0.023199999200000002 1 0.023200000000000002 0 0.023599999199999999 0 0.023599999999999999 1 0.0239999992 1 0.024 0 0.024399999200000001 0 0.024400000000000002 1 0.024799999200000002 1 0.024800000000000003 0 0.0251999992 0 0.0252 1 0.025599999200000001 1 0.025600000000000001 0 0.025999999200000002 0 0.026000000000000002 1 0.0263999992 1 0.0264 0 0.026799999200000001 0 0.026800000000000001 1 0.027199999200000002 1 0.027200000000000002 0 0.027599999200000003 0 0.027600000000000003 1 0.0279999992 1 0.028000000000000001 0 0.028399999200000001 0 0.028400000000000002 1 0.028799999200000002 1 0.028800000000000003 0 0.0291999992 0 0.0292 1 0.029599999200000001 1 0.029600000000000001 0 0.029999999200000002 0 0.030000000000000002 1 0.0303999992 1 0.0304 0 0.030799999200000001 0 0.030800000000000001 1 0.031199999200000002 1 0.031200000000000002 0 0.031599999200000006 0 0.031600000000000003 1 0.031999999200000004 1 0.032000000000000001 0 0.032399999200000001 0 0.032399999999999998 1 0.032799999200000006 1 0.032800000000000003 0 0.033199999200000004 0 0.0332 1 0.033599999200000008 1 0.033600000000000005 0 0.033999999200000006 0 0.034000000000000002 1 0.034399999200000003 1 0.0344 0 0.034799999200000008 0 0.034800000000000005 1 0.035199999200000005 1 0.035200000000000002 0 0.035599999200000003 0 0.0356 1 0.035999999200000007 1 0.036000000000000004 0 0.036399999200000005 0 0.036400000000000002 1 0.036799999200000003 1 0.036799999999999999 0 0.037199999200000007 0 0.037200000000000004 1 0.037599999200000005 1 0.037600000000000001 0 0.037999999200000002 0 0.037999999999999999 1 0.038399999200000007 1 0.038400000000000004 0 0.038799999200000004 0 0.038800000000000001 1 0.039199999200000002 1 0.039199999999999999 0 0.039599999200000006 0 0.039600000000000003 1 0.039999999200000004 1 0.040000000000000001 0 0.040399999200000009 0 0.040400000000000005 1 0.040799999200000006 1 0.040800000000000003 0 0.041199999200000004 0 0.041200000000000001 1 0.041599999200000008 1 0.041600000000000005 0 0.041999999200000006 0 0.042000000000000003 1 0.042399999200000003 1 0.0424 0 0.042799999200000008 0 0.042800000000000005 1 0.043199999200000005 1 0.043200000000000002 0 0.043599999200000003 0 0.0436 1 0.043999999200000008 1 0.044000000000000004 0 0.044399999200000005 0 0.044400000000000002 1 0.044799999200000003 1 0.0448 0 0.045199999200000007 0 0.045200000000000004 1 0.045599999200000005 1 0.045600000000000002 0 0.045999999200000002 0 0.045999999999999999 1 0.046399999200000007 1 0.046400000000000004 0 0.046799999200000005 0 0.046800000000000001 1 0.047199999200000002 1 0.047199999999999999 0 0.047599999200000007 0 0.047600000000000003 1 0.047999999200000004 1 0.048000000000000001 0 0.048399999200000009 0 0.048400000000000006 1 0.048799999200000006 1 0.048800000000000003 0 0.049199999200000004 0 0.049200000000000001 1 0.049599999200000008 1 0.049600000000000005 0 0.049999999200000006 0 0.050000000000000003 1 0.050399999200000004 1 0.0504 0 0.050799999200000008 0 0.050800000000000005 1 0.051199999200000006 1 0.051200000000000002 0 0.051599999200000003 0 0.0516 1 0.051999999200000008 1 0.052000000000000005 0 0.052399999200000005 0 0.052400000000000002 1 0.052799999200000003 1 0.0528 0 0.053199999200000007 0 0.053200000000000004 1 0.053599999200000005 1 0.053600000000000002 0 0.053999999200000003 0 0.053999999999999999 1 0.054399999200000007 1 0.054400000000000004 0 0.054799999200000005 0 0.054800000000000001 1 0.055199999200000009 1 0.055200000000000006 0 0.055599999200000007 0 0.055600000000000004 1 0.055999999200000004 1 0.056000000000000001 0 0.056399999200000009 0 0.056400000000000006 1 0.056799999200000006 1 0.056800000000000003 0 0.057199999200000004 0 0.057200000000000001 1 0.057599999200000009 1 0.057600000000000005 0 0.057999999200000006 0 0.058000000000000003 1 0.058399999200000004 1 0.058400000000000001 0 0.058799999200000008 0 0.058800000000000005 1 0.059199999200000006 1 0.059200000000000003 0 0.059599999200000003 0 0.0596 1 0.059999999200000008 1 0.060000000000000005 0 0.060399999200000005 0 0.060400000000000002 1 0.060799999200000003 1 0.0608 0 0.061199999200000008 0 0.061200000000000004 1 0.061599999200000005 1 0.061600000000000002 0 0.061999999200000003 0 0.062 1 0.062399999200000007 1 0.062400000000000004 0 0.062799999200000012 0 0.062800000000000009 1 0.063199999200000009 1 0.063200000000000006 0 0.063599999200000007 0 0.063600000000000004 1 0.063999999200000005 1 0.064000000000000001 0 0.064399999200000002 0 0.064399999999999999 1 0.0647999992 1 0.064799999999999996 0 0.065199999200000011 0 0.065200000000000008 1 0.065599999200000009 1 0.065600000000000006 0 0.065999999200000006 0 0.066000000000000003 1 0.066399999200000004 1 0.066400000000000001 0 0.066799999200000001 0 0.066799999999999998 1 0.067199999200000013 1 0.06720000000000001 0 0.067599999200000011 0 0.067600000000000007 1 0.067999999200000008 1 0.068000000000000005 0 0.068399999200000006 0 0.068400000000000002 1 0.068799999200000003 1 0.0688 0 0.069199999200000001 0 0.069199999999999998 1 0.069599999200000012 1 0.069600000000000009 0 0.06999999920000001 0 0.070000000000000007 1 0.070399999200000007 1 0.070400000000000004 0 0.070799999200000005 0 0.070800000000000002 1 0.071199999200000003 1 0.071199999999999999 0 0.0715999992 0 0.071599999999999997 1 0.071999999200000012 1 0.072000000000000008 0 0.072399999200000009 0 0.072400000000000006 1 0.072799999200000007 1 0.072800000000000004 0 0.073199999200000004 0 0.073200000000000001 1 0.073599999200000002 1 0.073599999999999999 0 0.073999999200000013 0 0.07400000000000001 1 0.074399999200000011 1 0.074400000000000008 0 0.074799999200000009 0 0.074800000000000005 1 0.075199999200000006 1 0.075200000000000003 0 0.075599999200000004 0 0.075600000000000001 1 0.075999999200000001 1 0.075999999999999998 0 0.076399999200000013 0 0.07640000000000001 1 0.07679999920000001 1 0.076800000000000007 0 0.077199999200000008 0 0.077200000000000005 1 0.077599999200000006 1 0.077600000000000002 0 0.077999999200000003 0 0.078 1 0.078399999200000001 1 0.078399999999999997 0 0.078799999200000012 0 0.078800000000000009 1 0.07919999920000001 1 0.079200000000000007 0 0.079599999200000007 0 0.079600000000000004 1 0.079999999200000005 1 0.080000000000000002 0 0.080399999200000002 0 0.080399999999999999 1 0.080799999200000014 1 0.080800000000000011 0 0.081199999200000011 0 0.081200000000000008 1 0.081599999200000009 1 0.081600000000000006 0 0.081999999200000007 0 0.082000000000000003 1 0.082399999200000004 1 0.082400000000000001 0 0.082799999200000002 0 0.082799999999999999 1 0.083199999200000013 1 0.08320000000000001 0 0.083599999200000011 0 0.083600000000000008 1 0.083999999200000008 1 0.084000000000000005 0 0.084399999200000006 0 0.084400000000000003 1 0.084799999200000004 1 0.0848 0 0.085199999200000001 0 0.085199999999999998 1 0.085599999200000013 1 0.085600000000000009 0 0.08599999920000001 0 0.086000000000000007 1 0.086399999200000008 1 0.086400000000000005 0 0.086799999200000005 0 0.086800000000000002 1 0.087199999200000003 1 0.0872 0 0.087599999200000001 0 0.087599999999999997 1 0.087999999200000012 1 0.088000000000000009 0 0.08839999920000001 0 0.088400000000000006 1 0.088799999200000007 1 0.088800000000000004 0 0.089199999200000005 0 0.089200000000000002 1 0.089599999200000002 1 0.089599999999999999 0 0.089999999200000014 0 0.090000000000000011 1 0.090399999200000011 1 0.090400000000000008 0 0.090799999200000009 0 0.090800000000000006 1 0.091199999200000006 1 0.091200000000000003 0 0.091599999200000004 0 0.091600000000000001 1 0.091999999200000002 1 0.091999999999999998 0 0.092399999200000013 0 0.09240000000000001 1 0.092799999200000011 1 0.092800000000000007 0 0.093199999200000008 0 0.093200000000000005 1 0.093599999200000006 1 0.093600000000000003 0 0.093999999200000003 0 0.094 1 0.094399999200000001 1 0.094399999999999998 0 0.094799999200000012 0 0.094800000000000009 1 0.09519999920000001 1 0.095200000000000007 0 0.095599999200000008 0 0.095600000000000004 1 0.095999999200000005 1 0.096000000000000002 0 0.096399999200000003 0 0.0964 1 0.096799999200000014 1 0.096800000000000011 0 0.097199999200000012 0 0.097200000000000009 1 0.097599999200000009 1 0.097600000000000006 0 0.097999999200000007 0 0.098000000000000004 1 0.098399999200000005 1 0.098400000000000001 0 0.098799999200000002 0 0.098799999999999999 1 0.099199999200000014 1 0.09920000000000001 0 0.099599999200000011 0 0.099600000000000008 1 0.099999999200000009 1 0.10000000000000001 0 0.10039999920000001 0 0.1004 1 0.1007999992 1 0.1008 0 0.1011999992 0 0.1012 1 0.10159999920000001 1 0.10160000000000001 0 0.10199999920000001 0 0.10200000000000001 1 0.10239999920000001 1 0.1024 0 0.10279999920000001 0 0.1028 1 0.1031999992 1 0.1032 0 0.10359999920000001 0 0.10360000000000001 1 0.10399999920000001 1 0.10400000000000001 0 0.10439999920000001 0 0.10440000000000001 1 0.10479999920000001 1 0.1048 0 0.10519999920000001 0 0.1052 1 0.1055999992 1 0.1056 0 0.10599999920000001 0 0.10600000000000001 1 0.10639999920000001 1 0.10640000000000001 0 0.10679999920000001 0 0.10680000000000001 1 0.10719999920000001 1 0.1072 0 0.1075999992 0 0.1076 1 0.1079999992 1 0.108 0 0.10839999920000001 0 0.10840000000000001 1 0.10879999920000001 1 0.10880000000000001 0 0.10919999920000001 0 0.10920000000000001 1 0.10959999920000001 1 0.1096 0 0.1099999992 0 0.11 1 0.11039999920000002 1 0.11040000000000001 0 0.11079999920000001 0 0.11080000000000001 1 0.11119999920000001 1 0.11120000000000001 0 0.11159999920000001 0 0.1116 1 0.11199999920000001 1 0.112 0 0.1123999992 0 0.1124 1 0.11279999920000001 1 0.11280000000000001 0 0.11319999920000001 0 0.11320000000000001 1 0.11359999920000001 1 0.11360000000000001 0 0.11399999920000001 0 0.114 1 0.1143999992 1 0.1144 0 0.1147999992 0 0.1148 1 0.11519999920000001 1 0.11520000000000001 0 0.11559999920000001 0 0.11560000000000001 1 0.11599999920000001 1 0.11600000000000001 0 0.11639999920000001 0 0.1164 1 0.1167999992 1 0.1168 0 0.11719999920000002 0 0.11720000000000001 1 0.11759999920000001 1 0.11760000000000001 0 0.11799999920000001 0 0.11800000000000001 1 0.11839999920000001 1 0.11840000000000001 0 0.11879999920000001 0 0.1188 1 0.1191999992 1 0.1192 0 0.11959999920000002 0 0.11960000000000001 1 0.11999999920000001 1 0.12000000000000001 0 0.12039999920000001 0 0.12040000000000001 1 0.12079999920000001 1 0.1208 0 0.12119999920000001 0 0.1212 1 0.1215999992 1 0.1216 0 0.12199999920000001 0 0.12200000000000001 1 0.12239999920000001 1 0.12240000000000001 0 0.12279999920000001 0 0.12280000000000001 1 0.12319999920000001 1 0.1232 0 0.1235999992 0 0.1236 1 0.1239999992 1 0.124 0 0.12439999920000001 0 0.12440000000000001 1 0.12479999920000001 1 0.12480000000000001 0 0.1251999992 0 0.12520000000000001 1 0.12559999920000001 1 0.12560000000000002 0 0.12599999919999999 0 0.126 1 0.1263999992 1 0.12640000000000001 0 0.12679999919999999 0 0.1268 1 0.1271999992 1 0.12720000000000001 0 0.12759999920000001 0 0.12760000000000002 1 0.12799999919999999 1 0.128 0 0.1283999992 0 0.12840000000000001 1 0.12879999919999999 1 0.1288 0 0.1291999992 0 0.12920000000000001 1 0.12959999919999998 1 0.12959999999999999 0 0.12999999919999999 0 0.13 1 0.13039999920000001 1 0.13040000000000002 0 0.13079999919999999 0 0.1308 1 0.1311999992 1 0.13120000000000001 0 0.13159999919999998 0 0.13159999999999999 1 0.1319999992 1 0.13200000000000001 0 0.13239999920000001 0 0.13240000000000002 1 0.13279999919999999 1 0.1328 0 0.1331999992 0 0.13320000000000001 1 0.13359999919999999 1 0.1336 0 0.1339999992 0 0.13400000000000001 1 0.13439999920000001 1 0.13440000000000002 0 0.13479999919999999 0 0.1348 1 0.1351999992 1 0.13520000000000001 0 0.13559999919999999 0 0.1356 1 0.1359999992 1 0.13600000000000001 0 0.13639999919999998 0 0.13639999999999999 1 0.13679999919999999 1 0.1368 0 0.13719999920000001 0 0.13720000000000002 1 0.13759999919999999 1 0.1376 0 0.1379999992 0 0.13800000000000001 1 0.13839999919999998 1 0.1384 0 0.1387999992 0 0.13880000000000001 1 0.13919999920000001 1 0.13920000000000002 0 0.13959999919999999 0 0.1396 1 0.1399999992 1 0.14000000000000001 0 0.14039999919999999 0 0.1404 1 0.1407999992 1 0.14080000000000001 0 0.14119999920000001 0 0.14120000000000002 1 0.14159999919999999 1 0.1416 0 0.1419999992 0 0.14200000000000002 1 0.14239999919999999 1 0.1424 0 0.1427999992 0 0.14280000000000001 1 0.14319999919999998 1 0.14319999999999999 0 0.14359999919999999 0 0.14360000000000001 1 0.14399999920000001 1 0.14400000000000002 0 0.14439999919999999 0 0.1444 1 0.1447999992 1 0.14480000000000001 0 0.14519999919999999 0 0.1452 1 0.1455999992 1 0.14560000000000001 0 0.14599999920000001 0 0.14600000000000002 1 0.14639999919999999 1 0.1464 0 0.1467999992 0 0.14680000000000001 1 0.14719999919999999 1 0.1472 0 0.1475999992 0 0.14760000000000001 1 0.14799999920000001 1 0.14800000000000002 0 0.14839999919999999 0 0.1484 1 0.1487999992 1 0.14880000000000002 0 0.14919999919999999 0 0.1492 1 0.1495999992 1 0.14960000000000001 0 0.14999999919999998 0 0.14999999999999999 1 0.1503999992 1 0.15040000000000001 0 0.15079999920000001 0 0.15080000000000002 1 0.15119999919999999 1 0.1512 0 0.1515999992 0 0.15160000000000001 1 0.15199999919999999 1 0.152 0 0.1523999992 0 0.15240000000000001 1 0.15279999920000001 1 0.15280000000000002 0 0.15319999919999999 0 0.1532 1 0.1535999992 1 0.15360000000000001 0 0.15399999919999999 0 0.154 1 0.1543999992 1 0.15440000000000001 0 0.15479999920000001 0 0.15480000000000002 1 0.15519999919999999 1 0.1552 0 0.15559999920000001 0 0.15560000000000002 1 0.15599999919999999 1 0.156 0 0.1563999992 0 0.15640000000000001 1 0.15679999919999998 1 0.15679999999999999 0 0.1571999992 0 0.15720000000000001 1 0.15759999920000001 1 0.15760000000000002 0 0.15799999919999999 0 0.158 1 0.1583999992 1 0.15840000000000001 0 0.15879999919999999 0 0.1588 1 0.1591999992 1 0.15920000000000001 0 0.15959999920000001 0 0.15960000000000002 1 0.15999999919999999 1 0.16 0 0.1603999992 0 0.16040000000000001 1 0.16079999919999999 1 0.1608 0 0.1611999992 0 0.16120000000000001 1 0.16159999920000001 1 0.16160000000000002 0 0.16199999919999999 0 0.16200000000000001 1 0.16239999920000001 1 0.16240000000000002 0 0.16279999919999999 0 0.1628 1 0.1631999992 1 0.16320000000000001 0 0.16359999919999998 0 0.1636 1 0.1639999992 1 0.16400000000000001 0 0.16439999920000001 0 0.16440000000000002 1 0.16479999919999999 1 0.1648 0 0.1651999992 0 0.16520000000000001 1 0.16559999919999999 1 0.1656 0 0.1659999992 0 0.16600000000000001 1 0.16639999920000001 1 0.16640000000000002 0 0.16679999919999999 0 0.1668 1 0.1671999992 1 0.16720000000000002 0 0.16759999919999999 0 0.1676 1 0.1679999992 1 0.16800000000000001 0 0.16839999920000001 0 0.16840000000000002 1 0.16879999919999999 1 0.16880000000000001 0 0.16919999920000001 0 0.16920000000000002 1 0.16959999919999999 1 0.1696 0 0.1699999992 0 0.17000000000000001 1 0.17039999919999999 1 0.1704 0 0.1707999992 0 0.17080000000000001 1 0.17119999920000001 1 0.17120000000000002 0 0.17159999919999999 0 0.1716 1 0.1719999992 1 0.17200000000000001 0 0.17239999919999999 0 0.1724 1 0.1727999992 1 0.17280000000000001 0 0.17319999920000001 0 0.17320000000000002 1 0.17359999919999999 1 0.1736 0 0.17399999920000001 0 0.17400000000000002 1 0.17439999919999999 1 0.1744 0 0.1747999992 0 0.17480000000000001 1 0.17519999919999998 1 0.17519999999999999 0 0.1755999992 0 0.17560000000000001 1 0.17599999920000001 1 0.17600000000000002 0 0.17639999919999999 0 0.1764 1 0.1767999992 1 0.17680000000000001 0 0.17719999919999999 0 0.1772 1 0.1775999992 1 0.17760000000000001 0 0.17799999920000001 0 0.17800000000000002 1 0.17839999919999999 1 0.1784 0 0.1787999992 0 0.17880000000000001 1 0.17919999919999999 1 0.1792 0 0.1795999992 0 0.17960000000000001 1 0.17999999920000001 1 0.18000000000000002 0 0.18039999919999999 0 0.1804 1 0.18079999920000001 1 0.18080000000000002 0 0.18119999919999999 0 0.1812 1 0.1815999992 1 0.18160000000000001 0 0.18199999919999998 0 0.182 1 0.1823999992 1 0.18240000000000001 0 0.18279999920000001 0 0.18280000000000002 1 0.18319999919999999 1 0.1832 0 0.1835999992 0 0.18360000000000001 1 0.18399999919999999 1 0.184 0 0.1843999992 0 0.18440000000000001 1 0.18479999920000001 1 0.18480000000000002 0 0.18519999919999999 0 0.1852 1 0.1855999992 1 0.18560000000000001 0 0.18599999919999999 0 0.186 1 0.1863999992 1 0.18640000000000001 0 0.18679999920000001 0 0.18680000000000002 1 0.18719999919999999 1 0.18720000000000001 0 0.18759999920000001 0 0.18760000000000002 1 0.18799999919999999 1 0.188 0 0.1883999992 0 0.18840000000000001 1 0.18879999919999998 1 0.1888 0 0.1891999992 0 0.18920000000000001 1 0.18959999920000001 1 0.18960000000000002 0 0.18999999919999999 0 0.19 1 0.1903999992 1 0.19040000000000001 0 0.19079999919999999 0 0.1908 1 0.1911999992 1 0.19120000000000001 0 0.19159999920000001 0 0.19160000000000002 1 0.19199999919999999 1 0.192 0 0.1923999992 0 0.19240000000000002 1 0.19279999919999999 1 0.1928 0 0.1931999992 0 0.19320000000000001 1 0.19359999920000001 1 0.19360000000000002 0 0.1939999992 0 0.19400000000000001 1 0.19439999920000001 1 0.19440000000000002 0 0.19479999919999999 0 0.1948 1 0.1951999992 1 0.19520000000000001 0 0.19559999919999999 0 0.1956 1 0.1959999992 1 0.19600000000000001 0 0.19639999920000001 0 0.19640000000000002 1 0.19679999919999999 1 0.1968 0 0.1971999992 0 0.19720000000000001 1 0.19759999919999999 1 0.1976 0 0.1979999992 0 0.19800000000000001 1 0.19839999920000001 1 0.19840000000000002 0 0.19879999919999999 0 0.1988 1 0.19919999920000001 1 0.19920000000000002 0 0.19959999919999999 0 0.1996 1 0.1999999992 1 0.20000000000000001 0 0.20039999920000001 0 0.20040000000000002 1 0.2007999992 1 0.20080000000000001 0)
N1 in_0 sample_clock out_0 dut
.model dut psi_vortex_student
.control
pre_osdi ../../psi_vortex_student.osdi
tran 4.0000000000000003e-05 0.20080000000000001 uic
wrdata osdi_output.txt v(out_0)
quit
.endc
.end
