`include "constants.vams"
`include "disciplines.vams"
module psi_vortex_student(in_0, sample_clock, out_0);
  input in_0, sample_clock;
  output out_0;
  electrical in_0, sample_clock, out_0;
  electrical state_0, state_1, state_2, state_3, state_4, state_5, state_6, state_7, candidate_0, candidate_1, candidate_2, candidate_3, candidate_4, candidate_5, candidate_6, candidate_7;
  real r_0;
  real r_1;
  real r_2;
  real r_3;
  real r_4;
  real r_5;
  real r_6;
  real r_7;
  real z_0;
  real z_1;
  real z_2;
  real z_3;
  real z_4;
  real z_5;
  real z_6;
  real z_7;
  real n_0;
  real n_1;
  real n_2;
  real n_3;
  real n_4;
  real n_5;
  real n_6;
  real n_7;
  real next_h_0;
  real next_h_1;
  real next_h_2;
  real next_h_3;
  real next_h_4;
  real next_h_5;
  real next_h_6;
  real next_h_7;
  real y_0;
  analog begin
    // Two-phase sample-and-hold realizes one chronological recurrent step.
    // Capacitive state is reset to zero by each independent transient run.
    I(state_0) <+ 9.9999999999999998e-13*ddt(V(state_0));
    I(candidate_0) <+ 9.9999999999999998e-13*ddt(V(candidate_0));
    I(state_1) <+ 9.9999999999999998e-13*ddt(V(state_1));
    I(candidate_1) <+ 9.9999999999999998e-13*ddt(V(candidate_1));
    I(state_2) <+ 9.9999999999999998e-13*ddt(V(state_2));
    I(candidate_2) <+ 9.9999999999999998e-13*ddt(V(candidate_2));
    I(state_3) <+ 9.9999999999999998e-13*ddt(V(state_3));
    I(candidate_3) <+ 9.9999999999999998e-13*ddt(V(candidate_3));
    I(state_4) <+ 9.9999999999999998e-13*ddt(V(state_4));
    I(candidate_4) <+ 9.9999999999999998e-13*ddt(V(candidate_4));
    I(state_5) <+ 9.9999999999999998e-13*ddt(V(state_5));
    I(candidate_5) <+ 9.9999999999999998e-13*ddt(V(candidate_5));
    I(state_6) <+ 9.9999999999999998e-13*ddt(V(state_6));
    I(candidate_6) <+ 9.9999999999999998e-13*ddt(V(candidate_6));
    I(state_7) <+ 9.9999999999999998e-13*ddt(V(state_7));
    I(candidate_7) <+ 9.9999999999999998e-13*ddt(V(candidate_7));
    r_0 = 1.0/(1.0 + exp(-(0.24861085414886475 + (0.39700672030448914)*(V(in_0)) + (0.49081659317016602)*(V(state_0)) + (0.14829558134078979)*(V(state_1)) + (0.036248192191123962)*(V(state_2)) + (-0.25003266334533691)*(V(state_3)) + (-0.25003266334533691)*(V(state_4)) + (0.14829558134078979)*(V(state_5)) + (-0.1686745285987854)*(V(state_6)) + (-0.1686745285987854)*(V(state_7)))));
    r_1 = 1.0/(1.0 + exp(-(0.70052224397659302 + (-0.25003266334533691)*(V(in_0)) + (0.49081659317016602)*(V(state_0)) + (0.14829558134078979)*(V(state_1)) + (0.39700672030448914)*(V(state_2)) + (-0.25003266334533691)*(V(state_3)) + (-0.34406238794326782)*(V(state_4)) + (-0.1686745285987854)*(V(state_5)) + (-0.25003266334533691)*(V(state_6)) + (-0.1686745285987854)*(V(state_7)))));
    r_2 = 1.0/(1.0 + exp(-(-0.40445917844772339 + (0.22055721282958984)*(V(in_0)) + (0.30351552367210388)*(V(state_0)) + (-0.34406238794326782)*(V(state_1)) + (-0.1686745285987854)*(V(state_2)) + (-0.44070735573768616)*(V(state_3)) + (-0.1686745285987854)*(V(state_4)) + (-0.25003266334533691)*(V(state_5)) + (-0.054904676973819733)*(V(state_6)) + (0.036248192191123962)*(V(state_7)))));
    r_3 = 1.0/(1.0 + exp(-(0.16565254330635071 + (0.22055721282958984)*(V(in_0)) + (0.30351552367210388)*(V(state_0)) + (-0.34406238794326782)*(V(state_1)) + (0.49081659317016602)*(V(state_2)) + (0.30351552367210388)*(V(state_3)) + (-0.25003266334533691)*(V(state_4)) + (-0.25003266334533691)*(V(state_5)) + (-0.054904676973819733)*(V(state_6)) + (-0.1686745285987854)*(V(state_7)))));
    r_4 = 1.0/(1.0 + exp(-(-0.01865648478269577 + (0.036248192191123962)*(V(in_0)) + (0.39700672030448914)*(V(state_0)) + (-0.054904676973819733)*(V(state_1)) + (0.59216463565826416)*(V(state_2)) + (0.14829558134078979)*(V(state_3)) + (-0.1686745285987854)*(V(state_4)) + (0.036248192191123962)*(V(state_5)) + (-0.62568998336791992)*(V(state_6)) + (-0.1686745285987854)*(V(state_7)))));
    r_5 = 1.0/(1.0 + exp(-(0.60703104734420776 + (0.036248192191123962)*(V(in_0)) + (-0.054904676973819733)*(V(state_0)) + (-0.52463752031326294)*(V(state_1)) + (0.59216463565826416)*(V(state_2)) + (-0.25003266334533691)*(V(state_3)) + (-0.054904676973819733)*(V(state_4)) + (0.036248192191123962)*(V(state_5)) + (-0.52463752031326294)*(V(state_6)) + (-0.62568998336791992)*(V(state_7)))));
    r_6 = 1.0/(1.0 + exp(-(0.45181110501289368 + (0.30351552367210388)*(V(in_0)) + (0.14829558134078979)*(V(state_0)) + (-0.44070735573768616)*(V(state_1)) + (0.49081659317016602)*(V(state_2)) + (-0.1686745285987854)*(V(state_3)) + (-0.1686745285987854)*(V(state_4)) + (-0.1686745285987854)*(V(state_5)) + (-0.25003266334533691)*(V(state_6)) + (-0.44070735573768616)*(V(state_7)))));
    r_7 = 1.0/(1.0 + exp(-(-0.30781418085098267 + (0.036248192191123962)*(V(in_0)) + (0.22055721282958984)*(V(state_0)) + (0.036248192191123962)*(V(state_1)) + (0.30351552367210388)*(V(state_2)) + (-0.1686745285987854)*(V(state_3)) + (-0.34406238794326782)*(V(state_4)) + (-0.25003266334533691)*(V(state_5)) + (-0.054904676973819733)*(V(state_6)) + (-0.054904676973819733)*(V(state_7)))));
    z_0 = 1.0/(1.0 + exp(-(0.71137380599975586 + (-0.054904676973819733)*(V(in_0)) + (-0.25003266334533691)*(V(state_0)) + (-0.054904676973819733)*(V(state_1)) + (0.49081659317016602)*(V(state_2)) + (0.22055721282958984)*(V(state_3)) + (-0.054904676973819733)*(V(state_4)) + (-0.34406238794326782)*(V(state_5)) + (0.22055721282958984)*(V(state_6)) + (-0.44070735573768616)*(V(state_7)))));
    z_1 = 1.0/(1.0 + exp(-(-0.13242633640766144 + (0.22055721282958984)*(V(in_0)) + (0.14829558134078979)*(V(state_0)) + (-0.1686745285987854)*(V(state_1)) + (-0.25003266334533691)*(V(state_2)) + (-0.1686745285987854)*(V(state_3)) + (0.49081659317016602)*(V(state_4)) + (0.036248192191123962)*(V(state_5)) + (0.30351552367210388)*(V(state_6)) + (0.22055721282958984)*(V(state_7)))));
    z_2 = 1.0/(1.0 + exp(-(-0.41870719194412231 + (0.036248192191123962)*(V(in_0)) + (-0.054904676973819733)*(V(state_0)) + (0.30351552367210388)*(V(state_1)) + (-0.25003266334533691)*(V(state_2)) + (0.30351552367210388)*(V(state_3)) + (0.036248192191123962)*(V(state_4)) + (0.036248192191123962)*(V(state_5)) + (0.30351552367210388)*(V(state_6)) + (0.30351552367210388)*(V(state_7)))));
    z_3 = 1.0/(1.0 + exp(-(-0.21378447115421295 + (0.39700672030448914)*(V(in_0)) + (-0.1686745285987854)*(V(state_0)) + (0.59216463565826416)*(V(state_1)) + (-0.054904676973819733)*(V(state_2)) + (-0.1686745285987854)*(V(state_3)) + (0.22055721282958984)*(V(state_4)) + (0.22055721282958984)*(V(state_5)) + (0.39700672030448914)*(V(state_6)) + (0.036248192191123962)*(V(state_7)))));
    z_4 = 1.0/(1.0 + exp(-(0.4332548975944519 + (-0.054904676973819733)*(V(in_0)) + (0.22055721282958984)*(V(state_0)) + (-0.054904676973819733)*(V(state_1)) + (0.49081659317016602)*(V(state_2)) + (0.036248192191123962)*(V(state_3)) + (0.14829558134078979)*(V(state_4)) + (-0.054904676973819733)*(V(state_5)) + (0.22055721282958984)*(V(state_6)) + (-0.34406238794326782)*(V(state_7)))));
    z_5 = 1.0/(1.0 + exp(-(0.4332548975944519 + (0.14829558134078979)*(V(in_0)) + (0.14829558134078979)*(V(state_0)) + (-0.1686745285987854)*(V(state_1)) + (0.39700672030448914)*(V(state_2)) + (0.036248192191123962)*(V(state_3)) + (0.30351552367210388)*(V(state_4)) + (-0.44070735573768616)*(V(state_5)) + (0.14829558134078979)*(V(state_6)) + (-0.52463752031326294)*(V(state_7)))));
    z_6 = 1.0/(1.0 + exp(-(0.45181110501289368 + (0.30351552367210388)*(V(in_0)) + (-0.25003266334533691)*(V(state_0)) + (-0.1686745285987854)*(V(state_1)) + (0.14829558134078979)*(V(state_2)) + (0.39700672030448914)*(V(state_3)) + (0.49081659317016602)*(V(state_4)) + (-0.054904676973819733)*(V(state_5)) + (-0.1686745285987854)*(V(state_6)) + (-0.054904676973819733)*(V(state_7)))));
    z_7 = 1.0/(1.0 + exp(-(0.053482860326766968 + (0.39700672030448914)*(V(in_0)) + (0.49081659317016602)*(V(state_0)) + (-0.1686745285987854)*(V(state_1)) + (-0.25003266334533691)*(V(state_2)) + (0.49081659317016602)*(V(state_3)) + (0.49081659317016602)*(V(state_4)) + (0.036248192191123962)*(V(state_5)) + (-0.52463752031326294)*(V(state_6)) + (-0.25003266334533691)*(V(state_7)))));
    n_0 = tanh((-0.25003266334533691 + (0.14829558134078979)*(V(in_0))) + r_0*(-0.44070735573768616 + (0.49081659317016602)*(V(state_0)) + (-0.44070735573768616)*(V(state_1)) + (0.30351552367210388)*(V(state_2)) + (0.14829558134078979)*(V(state_3)) + (-0.25003266334533691)*(V(state_4)) + (-0.44070735573768616)*(V(state_5)) + (-0.52463752031326294)*(V(state_6)) + (0.22055721282958984)*(V(state_7))));
    next_h_0 = (1.0-z_0)*n_0 + z_0*V(state_0);
    n_1 = tanh((0.39700672030448914 + (-0.054904676973819733)*(V(in_0))) + r_1*(-0.44070735573768616 + (-0.054904676973819733)*(V(state_0)) + (0.39700672030448914)*(V(state_1)) + (-0.52463752031326294)*(V(state_2)) + (-0.054904676973819733)*(V(state_3)) + (0.49081659317016602)*(V(state_4)) + (0.036248192191123962)*(V(state_5)) + (0.39700672030448914)*(V(state_6)) + (0.22055721282958984)*(V(state_7))));
    next_h_1 = (1.0-z_1)*n_1 + z_1*V(state_1);
    n_2 = tanh((0.30351552367210388 + (0.14829558134078979)*(V(in_0))) + r_2*(-0.25003266334533691 + (0.30351552367210388)*(V(state_0)) + (-0.1686745285987854)*(V(state_1)) + (-0.1686745285987854)*(V(state_2)) + (-0.054904676973819733)*(V(state_3)) + (0.22055721282958984)*(V(state_4)) + (-0.054904676973819733)*(V(state_5)) + (-0.1686745285987854)*(V(state_6)) + (-0.1686745285987854)*(V(state_7))));
    next_h_2 = (1.0-z_2)*n_2 + z_2*V(state_2);
    n_3 = tanh((0.39700672030448914 + (-0.1686745285987854)*(V(in_0))) + r_3*(0.30351552367210388 + (0.39700672030448914)*(V(state_0)) + (0.30351552367210388)*(V(state_1)) + (-0.054904676973819733)*(V(state_2)) + (-0.1686745285987854)*(V(state_3)) + (-0.25003266334533691)*(V(state_4)) + (-0.34406238794326782)*(V(state_5)) + (-0.34406238794326782)*(V(state_6)) + (-0.1686745285987854)*(V(state_7))));
    next_h_3 = (1.0-z_3)*n_3 + z_3*V(state_3);
    n_4 = tanh((0.22055721282958984 + (-0.1686745285987854)*(V(in_0))) + r_4*(-0.34406238794326782 + (-0.1686745285987854)*(V(state_0)) + (0.036248192191123962)*(V(state_1)) + (0.036248192191123962)*(V(state_2)) + (-0.25003266334533691)*(V(state_3)) + (0.14829558134078979)*(V(state_4)) + (0.14829558134078979)*(V(state_5)) + (0.70759314298629761)*(V(state_6)) + (0.14829558134078979)*(V(state_7))));
    next_h_4 = (1.0-z_4)*n_4 + z_4*V(state_4);
    n_5 = tanh((-0.054904676973819733 + (-0.25003266334533691)*(V(in_0))) + r_5*(-0.52463752031326294 + (-0.054904676973819733)*(V(state_0)) + (0.30351552367210388)*(V(state_1)) + (0.036248192191123962)*(V(state_2)) + (-0.34406238794326782)*(V(state_3)) + (0.39700672030448914)*(V(state_4)) + (0.39700672030448914)*(V(state_5)) + (0.14829558134078979)*(V(state_6)) + (0.036248192191123962)*(V(state_7))));
    next_h_5 = (1.0-z_5)*n_5 + z_5*V(state_5);
    n_6 = tanh((0.49081659317016602 + (-0.054904676973819733)*(V(in_0))) + r_6*(-0.25003266334533691 + (-0.34406238794326782)*(V(state_0)) + (0.14829558134078979)*(V(state_1)) + (-0.44070735573768616)*(V(state_2)) + (-0.34406238794326782)*(V(state_3)) + (0.39700672030448914)*(V(state_4)) + (0.30351552367210388)*(V(state_5)) + (0.036248192191123962)*(V(state_6)) + (0.036248192191123962)*(V(state_7))));
    next_h_6 = (1.0-z_6)*n_6 + z_6*V(state_6);
    n_7 = tanh((-0.44070735573768616 + (-0.1686745285987854)*(V(in_0))) + r_7*(0.22055721282958984 + (0.14829558134078979)*(V(state_0)) + (0.036248192191123962)*(V(state_1)) + (0.39700672030448914)*(V(state_2)) + (0.14829558134078979)*(V(state_3)) + (-0.1686745285987854)*(V(state_4)) + (-0.054904676973819733)*(V(state_5)) + (-0.44070735573768616)*(V(state_6)) + (-0.054904676973819733)*(V(state_7))));
    next_h_7 = (1.0-z_7)*n_7 + z_7*V(state_7);
    if (V(sample_clock) < 0.5) begin
      I(candidate_0) <+ 6.2499999999999997e-08*(V(candidate_0)-next_h_0);
      I(candidate_1) <+ 6.2499999999999997e-08*(V(candidate_1)-next_h_1);
      I(candidate_2) <+ 6.2499999999999997e-08*(V(candidate_2)-next_h_2);
      I(candidate_3) <+ 6.2499999999999997e-08*(V(candidate_3)-next_h_3);
      I(candidate_4) <+ 6.2499999999999997e-08*(V(candidate_4)-next_h_4);
      I(candidate_5) <+ 6.2499999999999997e-08*(V(candidate_5)-next_h_5);
      I(candidate_6) <+ 6.2499999999999997e-08*(V(candidate_6)-next_h_6);
      I(candidate_7) <+ 6.2499999999999997e-08*(V(candidate_7)-next_h_7);
    end else begin
      I(state_0) <+ 6.2499999999999997e-08*(V(state_0)-V(candidate_0));
      I(state_1) <+ 6.2499999999999997e-08*(V(state_1)-V(candidate_1));
      I(state_2) <+ 6.2499999999999997e-08*(V(state_2)-V(candidate_2));
      I(state_3) <+ 6.2499999999999997e-08*(V(state_3)-V(candidate_3));
      I(state_4) <+ 6.2499999999999997e-08*(V(state_4)-V(candidate_4));
      I(state_5) <+ 6.2499999999999997e-08*(V(state_5)-V(candidate_5));
      I(state_6) <+ 6.2499999999999997e-08*(V(state_6)-V(candidate_6));
      I(state_7) <+ 6.2499999999999997e-08*(V(state_7)-V(candidate_7));
    end
    y_0 = 0.036248192191123962 + (0.70759314298629761)*(V(state_0)) + (-0.71274691820144653)*(V(state_1)) + (0.036248192191123962)*(V(state_2)) + (0.59216463565826416)*(V(state_3)) + (-0.52463752031326294)*(V(state_4)) + (-0.52463752031326294)*(V(state_5)) + (-0.52463752031326294)*(V(state_6)) + (0.036248192191123962)*(V(state_7));
    V(out_0) <+ y_0;
  end
endmodule
